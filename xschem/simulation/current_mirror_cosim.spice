** sch_path: /home/ga/repos/ams-counter-xschem-tutorial/xschem/current_mirror_cosim.sch
**.subckt current_mirror_cosim
a1 [ CLK ] [ count_out3 count_out2 count_out1 count_out0 ] counter
V2 CLK 0 pulse 0 'VCC' 500n 10n 10n 490n 1u
M1 Vg Vg 0 0 nm w=2u l=1u
I0 net1 Vg 10u
V1 net1 0 1.5
M2 net3 Vg 0 0 nm w=2u l=1u
R5 net1 net2 0.1Meg
VAMM2 net2 net3 0
M3 net3 count_out0 net4 0 nm w=10u l=0.13u
M4 net4 Vg 0 0 nm w=2u l=1u
M5 net3 count_out1 net5 0 nm w=10u l=0.13u
M6 net5 Vg 0 0 nm w=2u l=1u
M7 net3 count_out2 net6 0 nm w=10u l=0.13u
M8 net6 Vg 0 0 nm w=2u l=1u
M9 net3 count_out3 net7 0 nm w=10u l=0.13u
M10 net7 Vg 0 0 nm w=2u l=1u
**** begin user architecture code

.temp 27

*.option method=gear
.param VCC=1.5

.control
save all
tran 1n 50u
*plot i(Vmeas) i(Vmeas1)
remzerovec
write current_mirror_cosim.raw
.endc

**** end user architecture code
**.ends
**** begin user architecture code
.model counter d_cosim simulation="ivlng" sim_args=["counter"] delay=0
.model nm nmos level=54 version=4.8.3
**** end user architecture code
.end
