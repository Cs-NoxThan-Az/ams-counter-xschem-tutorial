** sch_path: (generated from Xschem schematic current_mirror_cosim.sch)

a1 [ CLK ] [ count_out3 count_out2 count_out1 count_out0 ] counter
V2 CLK 0 pulse 0 'VCC' 500n 10n 10n 490n 1u
.model counter d_cosim simulation="ivlng" sim_args=["counter"] delay=0
.model nm nmos level=54 version=4.8.3

M1 Vg Vg 0 0 nm w=2u l=1u m=1
I0 net1 Vg 10u
V1 net1 0 1.5
VAMM2 net1 net3 0

M3 net3 count_out0 net4 0 nm w=10u l=0.13u  m=1
M4 net4 Vg 0 0 nm w=1u l=1u  m=1
M5 net3 count_out1 net5 0 nm w=10u l=0.13u  m=1
M6 net5 Vg 0 0 nm w=2u l=1u  m=1
M7 net3 count_out2 net6 0 nm w=10u l=0.13u  m=1
M8 net6 Vg 0 0 nm w=4u l=1u  m=1
M9 net3 count_out3 net7 0 nm w=10u l=0.13u  m=1
M10 net7 Vg 0 0 nm w=8u l=1u  m=1
**** begin user architecture code

.temp 27

.option method=gear
.param VCC=1.5

.control
tran 10n 50u
plot i(vamm2)*1e4 count_out0-8 count_out1-6 count_out2-4 count_out3-2
remzerovec
*write current_mirror_cosim.raw

.endc
.end
